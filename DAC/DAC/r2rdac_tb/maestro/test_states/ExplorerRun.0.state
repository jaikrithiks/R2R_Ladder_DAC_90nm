ADE simulation setup
Test DAC_r2rdac_tb_1: DAC/r2rdac_tb/schematic, simulator spectre
  Models: /home/install/FOUNDRY/analog/90nm/libs.oa22/gpdk090/../../models/spectre/gpdk090.scs[NN]
  Variables: t = 5u
  Temperature: 27
  Analysis tran: stop=350u errpreset=moderate
