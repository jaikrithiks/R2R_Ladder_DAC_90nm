ADE simulation setup
Test DAC_r2rdac_tb_1: DAC/r2rdac_tb/schematic, simulator spectre
  Models: /home/install/FOUNDRY/analog/90nm/libs.oa22/gpdk090/../../models/spectre/gpdk090.scs[NN]
  Variables: Vdd = 1.8; t = 5u
  Temperature: 27
  Analysis tran: stop=350u errpreset=moderate
Run mode: Single Run, Sweeps and Corners
Corners:
  model folders: /home/install/FOUNDRY/analog/90nm/libs.oa22/gpdk090/../../models/spectre
  Fast: temperature=27; gpdk090.scs[FF]
  Slow: temperature=27; gpdk090.scs[SS]
