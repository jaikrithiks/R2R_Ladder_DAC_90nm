ADE simulation setup
Run mode: Single Run, Sweeps and Corners
Tests:
  DAC_r2rdac_tb_1: DAC/r2rdac_tb/schematic, simulator spectre
    Variables: t = 5u; Vdd = 1.8
Corners:
  model folders: /home/install/FOUNDRY/analog/90nm/libs.oa22/gpdk090/../../models/spectre
  Fast: temperature=27; gpdk090.scs[FF]
  Slow: temperature=27; gpdk090.scs[SS]
